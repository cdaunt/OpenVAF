// SPDX-License-Identifier: GPL-3.0-or-later
// Parameter arithmetic must not make an affine Jacobian appear nonlinear.
`include "disciplines.vams"
module affine(p, n, drive);
    inout p, n, drive;
    electrical p, n, drive;
    (* type="instance" *) parameter real resistance=1.3;
    (* type="instance" *) parameter real offset=0;
    analog begin
        I(p,n) <+ sin(resistance)*V(p,n)/resistance
                  - 2*(offset+V(drive))/sqrt(resistance);
        I(p,n) <+ ddt(resistance*V(p,n));
    end
endmodule
